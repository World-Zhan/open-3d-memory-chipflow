* cell SG13G2_DCNDIODE
* pin CATHODE
.SUBCKT SG13G2_DCNDIODE 1
* net 1 CATHODE
* net 2 SUB!
* device instance D1 r0 *1 0,0 DANTENNA
DD1 2 1 DANTENNA A=35.003P P=58.08U m=2
.ENDS SG13G2_DCNDIODE
