* tap X reader regression
.subckt TOP T W Z
Xthree T W PTAP1 W=2u L=3u
.ends TOP
.end
