* tap X reader regression
.subckt TOP T W Z
Xbad T W PTAP1 A=1p P=4u PERIM=5u
.ends TOP
.end
