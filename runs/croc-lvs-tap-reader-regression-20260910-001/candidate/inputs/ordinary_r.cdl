* tap X reader regression
.subckt TOP T W Z
Rplain T W 10k R=10k
.ends TOP
.end
