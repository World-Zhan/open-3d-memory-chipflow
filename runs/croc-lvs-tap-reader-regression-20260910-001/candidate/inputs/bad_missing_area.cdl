* tap X reader regression
.subckt TOP T W Z
Xbad T W PTAP1 P=4u
.ends TOP
.end
